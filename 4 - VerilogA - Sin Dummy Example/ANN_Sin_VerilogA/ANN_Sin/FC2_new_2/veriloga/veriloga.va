// VerilogA for ANN_Sin, FC2_new_2, veriloga

`include "constants.vams"
`include "disciplines.vams"

module FC2_new_2(x,y);

  parameter integer x_dim = 1;
  parameter integer y_dim = 1;

  parameter real w2[0:2] = {0.00032372, 0.44065, -0.018568};
  parameter real b2 = 0.1864;
  real a;

  input [0:2]x;
  voltage [0:2]x;
  output y;
  voltage y;
  genvar i;

  analog begin
	a = 0;
  	for (i = 0; i <= 2; i = i + 1) begin
	 a = V(x[i]) * w2[i] + a;
	end
    V(y) <+ a + b2;
  end

endmodule
