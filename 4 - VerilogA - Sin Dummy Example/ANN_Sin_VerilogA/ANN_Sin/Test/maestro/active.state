ADE simulation setup
Test ANN_Sin:Test:1: ANN_Sin/Test/schematic, simulator spectre
  Temperature: 27
  Analysis tran: stop=20
  Signals: /net5 as Input, /a1<0> as Out_Fc1, /y1<0> as Out_Relu, /net2 as Out_Fc2
Run mode: Single Run, Sweeps and Corners
