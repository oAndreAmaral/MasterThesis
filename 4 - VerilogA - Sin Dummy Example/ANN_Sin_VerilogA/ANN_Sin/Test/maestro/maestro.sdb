ADE simulation setup
Run mode: Single Run, Sweeps and Corners
Tests:
  ANN_Sin:Test:1: ANN_Sin/Test/schematic, simulator spectre
    Outputs: /net3; Input; Out_Fc1; Out_Relu; Out_Fc2
