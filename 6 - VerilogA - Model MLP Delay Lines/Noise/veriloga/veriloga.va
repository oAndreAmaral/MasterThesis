// VerilogA for MLP_Thesis_Short, Noise, veriloga

`include "constants.vams"
`include "disciplines.vams"

module Noise(in_wave, out_wave);

  	input [0:1]in_wave;
  	voltage [0:1]in_wave;
 	output [0:1]out_wave;
  	voltage [0:1]out_wave;
	parameter real mean = -0.00004383777;
	parameter real stdv = 0.00025118375;
	parameter integer seed = 3;
	real a;
	real b[0:1];
	genvar i;

	analog begin

		a = $rdist_normal(seed, mean, stdv);

			for(i = 0; i<= 1; i = i + 1) begin
				b[i] = V(in_wave[i]) - a;
				V(out_wave[i]) <+ b[i];
			end

	end

endmodule
