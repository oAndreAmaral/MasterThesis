// VerilogA for MLP_Thesis_Final, Sigmoid, veriloga

`include "constants.vams"
`include "disciplines.vams"

module Sigmoid(n_deact, n_act);

  input n_deact;
  output n_act;
  electrical n_deact, n_act;
  real result;
  real p_num;
  parameter real alpha = 1;

  analog begin
	p_num = V(n_deact);
	result = 1/(1+exp(-p_num));
	V(n_act) <+ result;
  end
endmodule
