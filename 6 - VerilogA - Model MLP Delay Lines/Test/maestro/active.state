ADE simulation setup
Test MLP_Thesis_Final:Test:1: MLP_Thesis_Final/Test/schematic, simulator spectre
  Temperature: 27
  Analysis tran: stop=1
  Signals: /a5_s<0>, /a5_s<1>
Run mode: Single Run, Sweeps and Corners
