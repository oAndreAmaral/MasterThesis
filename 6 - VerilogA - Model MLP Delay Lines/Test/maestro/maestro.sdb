ADE simulation setup
Run mode: Single Run, Sweeps and Corners
Tests:
  MLP_Thesis_Final:Test:1: MLP_Thesis_Final/Test/schematic, simulator spectre
    Outputs: /a5_s<0>; /net04; /a1<0>; /z1<0>; /net012; /net2; /z1<33>; /a5_s<1>
