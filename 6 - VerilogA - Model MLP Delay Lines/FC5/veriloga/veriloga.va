// VerilogA for MLP_Thesis_Final, FC5, veriloga

`include "constants.vams"
`include "disciplines.vams"

module ANN_Middle_Layer_FC5(x,y);

  parameter real W20[0:1] = {-1.100478e-01,-5.454820e-02};
  parameter real W21[0:1] = {-1.572729e-01,-1.791562e-01};
  parameter real W22[0:1] = {-8.001725e-02,7.820061e-02};
  parameter real W23[0:1] = {1.034039e-01,1.151508e-01};
  parameter real W24[0:1] = {-3.276246e-01,-3.365295e-01};
  parameter real W25[0:1] = {-3.810350e-02,-3.460131e-02};
  parameter real W26[0:1] = {-1.309841e-02,-1.335310e-02};
  parameter real W27[0:1] = {-1.466282e-02,4.575387e-02};
  parameter real W28[0:1] = {-2.006957e-02,3.615907e-03};
  parameter real W29[0:1] = {-4.203635e-02,-4.456631e-02};
  parameter real W210[0:1] = {-1.683530e-01,-1.651862e-01};
  parameter real W211[0:1] = {2.317015e-01,1.980979e-01};
  parameter real W212[0:1] = {-3.838064e-01,-2.639143e-01};
  parameter real W213[0:1] = {9.656574e-02,5.471545e-02};
  parameter real W214[0:1] = {-2.142733e-01,-8.636492e-03};
  parameter real W215[0:1] = {-1.370242e-02,-6.421822e-03};
  parameter real W216[0:1] = {-1.104658e-01,-5.839828e-02};
  parameter real W217[0:1] = {-9.553961e-02,-9.107136e-02};
  parameter real W218[0:1] = {1.440580e-01,1.109670e-01};
  parameter real W219[0:1] = {2.366434e-02,-2.307625e-01};
  parameter real W220[0:1] = {4.545606e-02,1.099513e-02};
  parameter real W221[0:1] = {1.016278e-01,9.200785e-02};
  parameter real W222[0:1] = {8.788406e-03,-3.203946e-02};
  parameter real W223[0:1] = {-1.574924e-01,-1.908873e-01};
  parameter real W224[0:1] = {-1.930877e-02,1.127978e-02};
  parameter real b[0:1] = {1.921027e-01,1.411095e-01};
  real a2[0:1];

  input [0:24]x;
  voltage [0:24]x;
  output [0:1]y;
  voltage [0:1]y;
  genvar i;

  analog begin
      a2[0] = 0;
      a2[1] = 0;

      a2[0] = V(x[0]) * W20[0] + a2[0];
      a2[0] = V(x[1]) * W21[0] + a2[0];
      a2[0] = V(x[2]) * W22[0] + a2[0];
      a2[0] = V(x[3]) * W23[0] + a2[0];
      a2[0] = V(x[4]) * W24[0] + a2[0];
      a2[0] = V(x[5]) * W25[0] + a2[0];
      a2[0] = V(x[6]) * W26[0] + a2[0];
      a2[0] = V(x[7]) * W27[0] + a2[0];
      a2[0] = V(x[8]) * W28[0] + a2[0];
      a2[0] = V(x[9]) * W29[0] + a2[0];
      a2[0] = V(x[10]) * W210[0] + a2[0];
      a2[0] = V(x[11]) * W211[0] + a2[0];
      a2[0] = V(x[12]) * W212[0] + a2[0];
      a2[0] = V(x[13]) * W213[0] + a2[0];
      a2[0] = V(x[14]) * W214[0] + a2[0];
      a2[0] = V(x[15]) * W215[0] + a2[0];
      a2[0] = V(x[16]) * W216[0] + a2[0];
      a2[0] = V(x[17]) * W217[0] + a2[0];
      a2[0] = V(x[18]) * W218[0] + a2[0];
      a2[0] = V(x[19]) * W219[0] + a2[0];
      a2[0] = V(x[20]) * W220[0] + a2[0];
      a2[0] = V(x[21]) * W221[0] + a2[0];
      a2[0] = V(x[22]) * W222[0] + a2[0];
      a2[0] = V(x[23]) * W223[0] + a2[0];
      a2[0] = V(x[24]) * W224[0] + a2[0];
      a2[1] = V(x[0]) * W20[1] + a2[1];
      a2[1] = V(x[1]) * W21[1] + a2[1];
      a2[1] = V(x[2]) * W22[1] + a2[1];
      a2[1] = V(x[3]) * W23[1] + a2[1];
      a2[1] = V(x[4]) * W24[1] + a2[1];
      a2[1] = V(x[5]) * W25[1] + a2[1];
      a2[1] = V(x[6]) * W26[1] + a2[1];
      a2[1] = V(x[7]) * W27[1] + a2[1];
      a2[1] = V(x[8]) * W28[1] + a2[1];
      a2[1] = V(x[9]) * W29[1] + a2[1];
      a2[1] = V(x[10]) * W210[1] + a2[1];
      a2[1] = V(x[11]) * W211[1] + a2[1];
      a2[1] = V(x[12]) * W212[1] + a2[1];
      a2[1] = V(x[13]) * W213[1] + a2[1];
      a2[1] = V(x[14]) * W214[1] + a2[1];
      a2[1] = V(x[15]) * W215[1] + a2[1];
      a2[1] = V(x[16]) * W216[1] + a2[1];
      a2[1] = V(x[17]) * W217[1] + a2[1];
      a2[1] = V(x[18]) * W218[1] + a2[1];
      a2[1] = V(x[19]) * W219[1] + a2[1];
      a2[1] = V(x[20]) * W220[1] + a2[1];
      a2[1] = V(x[21]) * W221[1] + a2[1];
      a2[1] = V(x[22]) * W222[1] + a2[1];
      a2[1] = V(x[23]) * W223[1] + a2[1];
      a2[1] = V(x[24]) * W224[1] + a2[1];

      for(i = 0; i<= 1; i = i + 1) begin
          V(y[i]) <+ a2[i] + b[i];
      end
  end
endmodule
