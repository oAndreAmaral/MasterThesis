ADE simulation setup
Test MLP_Sin_Dims:Test:1: MLP_Sin_Dims/Test/schematic, simulator spectre
  Temperature: 27
  Analysis tran: stop=10
  Signals: /net6
Run mode: Single Run, Sweeps and Corners
