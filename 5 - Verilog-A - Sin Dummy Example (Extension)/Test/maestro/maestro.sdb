ADE simulation setup
Run mode: Single Run, Sweeps and Corners
Tests:
  MLP_Sin_Dims:Test:1: MLP_Sin_Dims/Test/schematic, simulator spectre
    Outputs: /a1<0>; "/z1_dims<2>"; /z1_dims<2>; "/z1_dims<0>"; "/z1_dims<7>"; "/z1_dims<3>"; "/z1_dims<4>"; "/z1_dims<5>"; "/z1_dims<6>"; /z1_dims<6>; "/z1_dims<8>"; "/z1_dims<1>"; /z1_dims<7>; /z1_dims<3>; /z1_dims<4>; /z1_dims<5>; /z1_dims<0>; /z1_dims<8>; /z1_dims<1>; /net6
